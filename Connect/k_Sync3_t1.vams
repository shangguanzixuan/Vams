`timescale 1ns/1ps

module k_Sync3_t1 (q, d, clk, rst_n);
    output logic q;
    input logic d, clk. rst_n;

    logic q1, q2;

    always @ (posedge clk or negedge rst_n)
    begin
        if (!rst_n)
            q <= '0;
            q1 <= '0;
            q2 <= '0;
        else
            q1 <= d;
            q2 <= q1;
            q <= q2;
    end
endmodule
