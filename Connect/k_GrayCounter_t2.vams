`timescale 1ns/1ps

module k_GrayCounter_t2 #(parameter size = 5)(
    output logic [size-1:0] gray,
    input logic clk, inc, ready, rst_n);

    logic [size-1:0] bin, bnxt, gnxt;
    integer ii = 0;

    always @ (posedge clk or negedge rst_n) begin
        if (!rst_n)
            gray <= '0;
            bin <= '0;
        else
            gray <= gnxt;
            bin <= bnxt;
    end

    assign bnxt = ready ? bin + inc : bin;

    // instantiate binary to gray code converter
    k_b2g_converter_t1 #(.size(size)) b2g (.gray(gnxt),
                                           .bin(bnxt));

endmodule
